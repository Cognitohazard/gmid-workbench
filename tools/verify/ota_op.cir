* 5T OTA from sheets/otas/five-transistor-ota.json at its sky130 tt 27C defaults: operating point
*
* The sheet evaluated at its shipped defaults on the sky130 tt 27 C tables: the bias reference,
* tail and pair on sky130_fd_pr__nfet_01v8, both mirror-load devices on sky130_fd_pr__pfet_01v8
* (ld_sign = -1). VDD 1.8 V, CL 2 pF, programmed current 20 uA, CM_dc 1.1 V, V_out_dc 0.9 V,
* every length 0.5 um. What the sheet reports, to compare with what this deck prints:
*
*   block               W [um]  id [uA]  vgs [mV]  gm [uS]  gm/id
*   bias  (XMB)         2.5031  20.000     810.56  200.00   10.00   diode-connected, programmed
*   tail  (XMT)         2.5031  18.103     810.56  179.73    9.93   bias gate, vds = V_tail
*   in    (XM2)         1.7808   8.9782    825.04  107.74   12.00   pair, output side: 49.60 % of the tail's
*   ldr   (XM3)         2.5797   9.1243  -1132.19   72.99    8.00   diode side of the load: the rest
*   inr   (XM1)         1.7808   9.1243    829.82  107.29   11.76   pair, diode side: in's W, the rest of the tail
*   ld    (XM4)         2.5797   8.9782  -1132.19   71.90    8.01   output side, ldr's gate
*
*   V_tail 272.57 mV   tail__id = I_q 18.103 uA   out_share 0.4960   vos_sys 4.7845 mV
*   in__gds 1.3346 uS   ld__gds 0.6774 uS   Rout 497.02 kohm   gm_pair 106.71 uS   Av 53.04
*
* The sheet draws the OTA at rest, the state this deck puts it in: the output held at V_out_dc,
* the two inputs apart by the offset that takes. The split of the tail current is solved so the
* output node's currents balance (in carries what ld returns), and vos_sys is the difference of
* the two pair transistors' gate-source voltages, inr__vgs - in__vgs. v(os) is what to hold
* against it, and the pair and load rows against the rows above.
*
* Widths. The tables are characterized at W = 1 um, and the sheet scales them per um. Each
* device here is that same 1 um single-finger device with a multiplier m equal to the sized
* width in um. None of the widths is a whole number of microns, so m is fractional: this is
* the table's own scaling assumption rather than a layout, and it keeps the comparison about
* the sheet's arithmetic. See the README for what whole fingers and single fingers do instead.
*
* Output level. Nothing inside a 5T OTA holds its output node, and the sheet says the feedback
* around the amplifier holds it at V_out_dc. A servo stands in for that feedback: an ideal
* integrator (GSV into CSV) compares v(out) with V_out_dc and its output v(os) is applied as a
* differential input, split evenly about CM_dc. At DC the integrator's gain is unbounded, so
* v(out) = V_out_dc exactly and v(os) is the input offset that takes. The loop's unity-gain
* frequency is about 10 uHz, so it is open at every frequency ota_ac.cir and ota_noise.cir use.
*
* The circuit section below is identical in ota_op.cir, ota_ac.cir and ota_noise.cir.
.param mc_mm_switch=0
.param mc_pr_switch=0
.include .pdk/sky130A/libs.tech/ngspice/corners/tt.spice

VDD  vdd  0    1.8
IB   vdd  nb   20u
XMB  nb   nb   0    0    sky130_fd_pr__nfet_01v8 L=0.5 W=1 nf=1 m=2.5031
XMT  tail nb   0    0    sky130_fd_pr__nfet_01v8 L=0.5 W=1 nf=1 m=2.5031
XM1  n1   inp  tail 0    sky130_fd_pr__nfet_01v8 L=0.5 W=1 nf=1 m=1.7808
XM2  out  inn  tail 0    sky130_fd_pr__nfet_01v8 L=0.5 W=1 nf=1 m=1.7808
XM3  n1   n1   vdd  vdd  sky130_fd_pr__pfet_01v8 L=0.5 W=1 nf=1 m=2.5797
XM4  out  n1   vdd  vdd  sky130_fd_pr__pfet_01v8 L=0.5 W=1 nf=1 m=2.5797
CL   out  0    2p

* inputs: v(inp) - v(inn) = VID + v(os), centred on CM_dc
VCM  cm   0    1.1
VID  dif  os   dc 0 ac 1
EP   inp  cm   dif 0  0.5
EN   inn  cm   dif 0 -0.5

* output servo: integrates V_out_dc - v(out) onto node os
VREF ref  0    0.9
GSV  0    os   ref out 1u
CSV  os   0    1

.control
op
let id_bias = @m.xmb.msky130_fd_pr__nfet_01v8[id]
let gm_bias = @m.xmb.msky130_fd_pr__nfet_01v8[gm]
let id_tail = @m.xmt.msky130_fd_pr__nfet_01v8[id]
let gm_tail = @m.xmt.msky130_fd_pr__nfet_01v8[gm]
let gds_tail = @m.xmt.msky130_fd_pr__nfet_01v8[gds]
let id_in1 = @m.xm1.msky130_fd_pr__nfet_01v8[id]
let gm_in1 = @m.xm1.msky130_fd_pr__nfet_01v8[gm]
let id_in2 = @m.xm2.msky130_fd_pr__nfet_01v8[id]
let gm_in2 = @m.xm2.msky130_fd_pr__nfet_01v8[gm]
let gds_in2 = @m.xm2.msky130_fd_pr__nfet_01v8[gds]
let id_ldr = @m.xm3.msky130_fd_pr__pfet_01v8[id]
let gm_ldr = @m.xm3.msky130_fd_pr__pfet_01v8[gm]
let id_ld = @m.xm4.msky130_fd_pr__pfet_01v8[id]
let gm_ld = @m.xm4.msky130_fd_pr__pfet_01v8[gm]
let gds_ld = @m.xm4.msky130_fd_pr__pfet_01v8[gds]
echo
echo "== bias reference (XMB): vgs is v(nb)"
print id_bias gm_bias gm_bias/id_bias v(nb)
echo "== tail (XMT): on the reference's gate, vds is V_tail = v(tail)"
print id_tail id_tail/id_bias gm_tail gm_tail/id_tail gds_tail v(tail)
echo "== pair, diode side (XM1, the sheet's inr)"
print id_in1 gm_in1 gm_in1/id_in1 v(inp)-v(tail) v(n1)-v(tail)
echo "== pair, output side (XM2, the sheet's in)"
print id_in2 gm_in2 gm_in2/id_in2 gds_in2 v(inn)-v(tail) v(out)-v(tail)
echo "== load, diode side (XM3, the sheet's ldr)"
print id_ldr gm_ldr gm_ldr/id_ldr v(n1)-v(vdd)
echo "== load, output side (XM4, the sheet's ld)"
print id_ld gm_ld gm_ld/id_ld gds_ld v(out)-v(vdd)
echo "== output held at V_out_dc, and what it costs"
print v(out) v(os) id_ldr-id_ld id_in2-id_in1
echo "== small-signal estimate from the output-node conductances"
print 1/(gds_in2+gds_ld) gm_in2/(gds_in2+gds_ld)
.endc
.end
