* single-device noise reference: pfet_01v8 at the 5T OTA's mirror-load bias point
*
* One device held at exactly the coordinates the sheet's ldr block (the diode side of the
* mirror load) was read at (see ota_op.cir): W 2.5268 um as m copies of the 1 um device,
* L 0.5 um, vgs = vds = -1132.19 mV, vsb 0. There the sheet reports
*
*   id 8.9374 uA   gm 71.50 uS   ldr__vnth_m 15.23 nV/rtHz (4kT*gamma/gm with gamma = 1)
*
* No load and no topology: the drain sits on a voltage source and HO turns its current into
* v(o) at 1 V/A, so the output noise is the drain noise current in A/rtHz and the gain from
* VG is gm. Dividing by gm gives the device's own input-referred density; in the OTA it is
* referred to the input by a further gm(load)/gm(pair). The sweep is 100 points per decade
* from 1 Hz, so index 300 is 1 kHz and index 800 is 100 MHz.
.param mc_mm_switch=0
.param mc_pr_switch=0
.include ~/.volare/sky130A/libs.tech/ngspice/corners/tt.spice

VG   g    0    dc -1.13219 ac 1
VD   d    0    -1.13219
XM1  d    g    0    0    sky130_fd_pr__pfet_01v8 L=0.5 W=1 nf=1 m=2.5268
HO   o    0    VD   1

.control
op
let id = @m.xm1.msky130_fd_pr__pfet_01v8[id]
let gm = @m.xm1.msky130_fd_pr__pfet_01v8[gm]
echo
echo "== operating point"
print id gm gm/id
noise v(o) VG dec 100 1 10g 1
setplot noise1
let thermal = onoise.m.xm1.msky130_fd_pr__pfet_01v8.id
let flicker = onoise.m.xm1.msky130_fd_pr__pfet_01v8.1overf
let vn_total = inoise_spectrum
let vn_thermal = thermal/op1.gm
let vn_flicker = flicker/op1.gm
* thermal drain-current density over 4kT*gm at 27 C
let gamma_eff = thermal^2/(4*1.380649e-23*300.15*op1.gm)
* the flicker part falls with frequency, so the fraction of the ten-decade sweep on which it
* exceeds the thermal part locates the crossing
let f_corner = 10^(10*mean(flicker gt thermal))
echo "== input-referred density [V/rtHz] at 1 kHz: total, thermal part, flicker part"
print vn_total[300] vn_thermal[300] vn_flicker[300]
echo "== at 100 MHz"
print vn_total[800] vn_thermal[800] vn_flicker[800]
echo "== effective gamma, and the frequency where flicker falls to thermal [Hz]"
print gamma_eff[300] f_corner
.endc
.end
